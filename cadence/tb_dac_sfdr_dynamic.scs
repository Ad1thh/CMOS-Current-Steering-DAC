// Spectre Testbench: 200 MS/s Dynamic Sine Wave Reconstruction for SFDR
simulator lang=spectre
global 0
include "/home/install/FOUNDRY/analog/180nm/models/spectre/gpdk.scs" section=NN
include "dac_6bit_top.scs"

V_DD (VDD 0) vsource dc=1.8
V_SS (VSS 0) vsource dc=0.0

V_D0 (D0 0) vsource type=pwl wave=[ 0.000e+00 0.0 4.920e-09 0.0 5.000e-09 0.0 9.920e-09 0.0 1.000e-08 1.8 1.492e-08 1.8 1.500e-08 1.8 1.992e-08 1.8 2.000e-08 1.8 2.492e-08 1.8 2.500e-08 0.0 2.992e-08 0.0 3.000e-08 0.0 3.492e-08 0.0 3.500e-08 1.8 3.992e-08 1.8 4.000e-08 1.8 4.492e-08 1.8 4.500e-08 0.0 4.992e-08 0.0 5.000e-08 1.8 5.492e-08 1.8 5.500e-08 0.0 5.992e-08 0.0 6.000e-08 0.0 6.492e-08 0.0 6.500e-08 0.0 6.992e-08 0.0 7.000e-08 0.0 7.492e-08 0.0 7.500e-08 1.8 7.992e-08 1.8 8.000e-08 0.0 8.492e-08 0.0 8.500e-08 1.8 8.992e-08 1.8 9.000e-08 0.0 9.492e-08 0.0 9.500e-08 0.0 9.992e-08 0.0 1.000e-07 0.0 1.049e-07 0.0 1.050e-07 0.0 1.099e-07 0.0 1.100e-07 0.0 1.149e-07 0.0 1.150e-07 0.0 1.199e-07 0.0 1.200e-07 1.8 1.249e-07 1.8 1.250e-07 0.0 1.299e-07 0.0 1.300e-07 0.0 1.349e-07 0.0 1.350e-07 1.8 1.399e-07 1.8 1.400e-07 0.0 1.449e-07 0.0 1.450e-07 1.8 1.499e-07 1.8 1.500e-07 0.0 1.549e-07 0.0 1.550e-07 0.0 1.599e-07 0.0 1.600e-07 0.0 1.649e-07 0.0 1.650e-07 0.0 1.699e-07 0.0 1.700e-07 0.0 1.749e-07 0.0 1.750e-07 1.8 1.799e-07 1.8 1.800e-07 0.0 1.849e-07 0.0 1.850e-07 1.8 1.899e-07 1.8 1.900e-07 0.0 1.949e-07 0.0 1.950e-07 0.0 1.999e-07 0.0 2.000e-07 1.8 2.049e-07 1.8 2.050e-07 0.0 2.099e-07 0.0 2.100e-07 0.0 2.149e-07 0.0 2.150e-07 0.0 2.199e-07 0.0 2.200e-07 0.0 2.249e-07 0.0 2.250e-07 0.0 2.299e-07 0.0 2.300e-07 0.0 2.349e-07 0.0 2.350e-07 1.8 2.399e-07 1.8 2.400e-07 0.0 2.449e-07 0.0 2.450e-07 1.8 2.499e-07 1.8 2.500e-07 0.0 2.549e-07 0.0 2.550e-07 0.0 2.599e-07 0.0 2.600e-07 0.0 2.649e-07 0.0 2.650e-07 0.0 2.699e-07 0.0 2.700e-07 1.8 2.749e-07 1.8 2.750e-07 0.0 2.799e-07 0.0 2.800e-07 1.8 2.849e-07 1.8 2.850e-07 1.8 2.899e-07 1.8 2.900e-07 0.0 2.949e-07 0.0 2.950e-07 0.0 2.999e-07 0.0 3.000e-07 1.8 3.049e-07 1.8 3.050e-07 1.8 3.099e-07 1.8 3.100e-07 1.8 3.149e-07 1.8 3.150e-07 0.0 3.199e-07 0.0 3.200e-07 0.0 3.249e-07 0.0 3.250e-07 1.8 3.299e-07 1.8 3.300e-07 0.0 3.349e-07 0.0 3.350e-07 0.0 3.399e-07 0.0 3.400e-07 0.0 3.449e-07 0.0 3.450e-07 1.8 3.499e-07 1.8 3.500e-07 1.8 3.549e-07 1.8 3.550e-07 0.0 3.599e-07 0.0 3.600e-07 0.0 3.649e-07 0.0 3.650e-07 1.8 3.699e-07 1.8 3.700e-07 0.0 3.749e-07 0.0 3.750e-07 1.8 3.799e-07 1.8 3.800e-07 1.8 3.849e-07 1.8 3.850e-07 1.8 3.899e-07 1.8 3.900e-07 1.8 3.949e-07 1.8 3.950e-07 0.0 3.999e-07 0.0 4.000e-07 1.8 4.049e-07 1.8 4.050e-07 0.0 4.099e-07 0.0 4.100e-07 1.8 4.149e-07 1.8 4.150e-07 1.8 4.199e-07 1.8 4.200e-07 1.8 4.249e-07 1.8 4.250e-07 1.8 4.299e-07 1.8 4.300e-07 1.8 4.349e-07 1.8 4.350e-07 1.8 4.399e-07 1.8 4.400e-07 0.0 4.449e-07 0.0 4.450e-07 1.8 4.499e-07 1.8 4.500e-07 1.8 4.549e-07 1.8 4.550e-07 0.0 4.599e-07 0.0 4.600e-07 1.8 4.649e-07 1.8 4.650e-07 0.0 4.699e-07 0.0 4.700e-07 1.8 4.749e-07 1.8 4.750e-07 1.8 4.799e-07 1.8 4.800e-07 0.0 4.849e-07 0.0 4.850e-07 1.8 4.899e-07 1.8 4.900e-07 1.8 4.949e-07 1.8 4.950e-07 0.0 4.999e-07 0.0 5.000e-07 1.8 5.049e-07 1.8 5.050e-07 0.0 5.099e-07 0.0 5.100e-07 1.8 5.149e-07 1.8 5.150e-07 1.8 5.199e-07 1.8 5.200e-07 0.0 5.249e-07 0.0 5.250e-07 1.8 5.299e-07 1.8 5.300e-07 1.8 5.349e-07 1.8 5.350e-07 1.8 5.399e-07 1.8 5.400e-07 1.8 5.449e-07 1.8 5.450e-07 1.8 5.499e-07 1.8 5.500e-07 1.8 5.549e-07 1.8 5.550e-07 0.0 5.599e-07 0.0 5.600e-07 1.8 5.649e-07 1.8 5.650e-07 0.0 5.699e-07 0.0 5.700e-07 1.8 5.749e-07 1.8 5.750e-07 1.8 5.799e-07 1.8 5.800e-07 1.8 5.849e-07 1.8 5.850e-07 1.8 5.899e-07 1.8 5.900e-07 0.0 5.949e-07 0.0 5.950e-07 1.8 5.999e-07 1.8 6.000e-07 0.0 6.049e-07 0.0 6.050e-07 0.0 6.099e-07 0.0 6.100e-07 1.8 6.149e-07 1.8 6.150e-07 1.8 6.199e-07 1.8 6.200e-07 0.0 6.249e-07 0.0 6.250e-07 0.0 6.299e-07 0.0 6.300e-07 0.0 6.349e-07 0.0 6.350e-07 1.8 6.399e-07 1.8 ]
V_DB0 (DB0 0) vsource type=pwl wave=[ 0.000e+00 1.8 4.920e-09 1.8 5.000e-09 1.8 9.920e-09 1.8 1.000e-08 0.0 1.492e-08 0.0 1.500e-08 0.0 1.992e-08 0.0 2.000e-08 0.0 2.492e-08 0.0 2.500e-08 1.8 2.992e-08 1.8 3.000e-08 1.8 3.492e-08 1.8 3.500e-08 0.0 3.992e-08 0.0 4.000e-08 0.0 4.492e-08 0.0 4.500e-08 1.8 4.992e-08 1.8 5.000e-08 0.0 5.492e-08 0.0 5.500e-08 1.8 5.992e-08 1.8 6.000e-08 1.8 6.492e-08 1.8 6.500e-08 1.8 6.992e-08 1.8 7.000e-08 1.8 7.492e-08 1.8 7.500e-08 0.0 7.992e-08 0.0 8.000e-08 1.8 8.492e-08 1.8 8.500e-08 0.0 8.992e-08 0.0 9.000e-08 1.8 9.492e-08 1.8 9.500e-08 1.8 9.992e-08 1.8 1.000e-07 1.8 1.049e-07 1.8 1.050e-07 1.8 1.099e-07 1.8 1.100e-07 1.8 1.149e-07 1.8 1.150e-07 1.8 1.199e-07 1.8 1.200e-07 0.0 1.249e-07 0.0 1.250e-07 1.8 1.299e-07 1.8 1.300e-07 1.8 1.349e-07 1.8 1.350e-07 0.0 1.399e-07 0.0 1.400e-07 1.8 1.449e-07 1.8 1.450e-07 0.0 1.499e-07 0.0 1.500e-07 1.8 1.549e-07 1.8 1.550e-07 1.8 1.599e-07 1.8 1.600e-07 1.8 1.649e-07 1.8 1.650e-07 1.8 1.699e-07 1.8 1.700e-07 1.8 1.749e-07 1.8 1.750e-07 0.0 1.799e-07 0.0 1.800e-07 1.8 1.849e-07 1.8 1.850e-07 0.0 1.899e-07 0.0 1.900e-07 1.8 1.949e-07 1.8 1.950e-07 1.8 1.999e-07 1.8 2.000e-07 0.0 2.049e-07 0.0 2.050e-07 1.8 2.099e-07 1.8 2.100e-07 1.8 2.149e-07 1.8 2.150e-07 1.8 2.199e-07 1.8 2.200e-07 1.8 2.249e-07 1.8 2.250e-07 1.8 2.299e-07 1.8 2.300e-07 1.8 2.349e-07 1.8 2.350e-07 0.0 2.399e-07 0.0 2.400e-07 1.8 2.449e-07 1.8 2.450e-07 0.0 2.499e-07 0.0 2.500e-07 1.8 2.549e-07 1.8 2.550e-07 1.8 2.599e-07 1.8 2.600e-07 1.8 2.649e-07 1.8 2.650e-07 1.8 2.699e-07 1.8 2.700e-07 0.0 2.749e-07 0.0 2.750e-07 1.8 2.799e-07 1.8 2.800e-07 0.0 2.849e-07 0.0 2.850e-07 0.0 2.899e-07 0.0 2.900e-07 1.8 2.949e-07 1.8 2.950e-07 1.8 2.999e-07 1.8 3.000e-07 0.0 3.049e-07 0.0 3.050e-07 0.0 3.099e-07 0.0 3.100e-07 0.0 3.149e-07 0.0 3.150e-07 1.8 3.199e-07 1.8 3.200e-07 1.8 3.249e-07 1.8 3.250e-07 0.0 3.299e-07 0.0 3.300e-07 1.8 3.349e-07 1.8 3.350e-07 1.8 3.399e-07 1.8 3.400e-07 1.8 3.449e-07 1.8 3.450e-07 0.0 3.499e-07 0.0 3.500e-07 0.0 3.549e-07 0.0 3.550e-07 1.8 3.599e-07 1.8 3.600e-07 1.8 3.649e-07 1.8 3.650e-07 0.0 3.699e-07 0.0 3.700e-07 1.8 3.749e-07 1.8 3.750e-07 0.0 3.799e-07 0.0 3.800e-07 0.0 3.849e-07 0.0 3.850e-07 0.0 3.899e-07 0.0 3.900e-07 0.0 3.949e-07 0.0 3.950e-07 1.8 3.999e-07 1.8 4.000e-07 0.0 4.049e-07 0.0 4.050e-07 1.8 4.099e-07 1.8 4.100e-07 0.0 4.149e-07 0.0 4.150e-07 0.0 4.199e-07 0.0 4.200e-07 0.0 4.249e-07 0.0 4.250e-07 0.0 4.299e-07 0.0 4.300e-07 0.0 4.349e-07 0.0 4.350e-07 0.0 4.399e-07 0.0 4.400e-07 1.8 4.449e-07 1.8 4.450e-07 0.0 4.499e-07 0.0 4.500e-07 0.0 4.549e-07 0.0 4.550e-07 1.8 4.599e-07 1.8 4.600e-07 0.0 4.649e-07 0.0 4.650e-07 1.8 4.699e-07 1.8 4.700e-07 0.0 4.749e-07 0.0 4.750e-07 0.0 4.799e-07 0.0 4.800e-07 1.8 4.849e-07 1.8 4.850e-07 0.0 4.899e-07 0.0 4.900e-07 0.0 4.949e-07 0.0 4.950e-07 1.8 4.999e-07 1.8 5.000e-07 0.0 5.049e-07 0.0 5.050e-07 1.8 5.099e-07 1.8 5.100e-07 0.0 5.149e-07 0.0 5.150e-07 0.0 5.199e-07 0.0 5.200e-07 1.8 5.249e-07 1.8 5.250e-07 0.0 5.299e-07 0.0 5.300e-07 0.0 5.349e-07 0.0 5.350e-07 0.0 5.399e-07 0.0 5.400e-07 0.0 5.449e-07 0.0 5.450e-07 0.0 5.499e-07 0.0 5.500e-07 0.0 5.549e-07 0.0 5.550e-07 1.8 5.599e-07 1.8 5.600e-07 0.0 5.649e-07 0.0 5.650e-07 1.8 5.699e-07 1.8 5.700e-07 0.0 5.749e-07 0.0 5.750e-07 0.0 5.799e-07 0.0 5.800e-07 0.0 5.849e-07 0.0 5.850e-07 0.0 5.899e-07 0.0 5.900e-07 1.8 5.949e-07 1.8 5.950e-07 0.0 5.999e-07 0.0 6.000e-07 1.8 6.049e-07 1.8 6.050e-07 1.8 6.099e-07 1.8 6.100e-07 0.0 6.149e-07 0.0 6.150e-07 0.0 6.199e-07 0.0 6.200e-07 1.8 6.249e-07 1.8 6.250e-07 1.8 6.299e-07 1.8 6.300e-07 1.8 6.349e-07 1.8 6.350e-07 0.0 6.399e-07 0.0 ]

V_D1 (D1 0) vsource type=pwl wave=[ 0.000e+00 0.0 4.920e-09 0.0 5.000e-09 1.8 9.920e-09 1.8 1.000e-08 0.0 1.492e-08 0.0 1.500e-08 0.0 1.992e-08 0.0 2.000e-08 0.0 2.492e-08 0.0 2.500e-08 1.8 2.992e-08 1.8 3.000e-08 0.0 3.492e-08 0.0 3.500e-08 0.0 3.992e-08 0.0 4.000e-08 1.8 4.492e-08 1.8 4.500e-08 0.0 4.992e-08 0.0 5.000e-08 1.8 5.492e-08 1.8 5.500e-08 0.0 5.992e-08 0.0 6.000e-08 1.8 6.492e-08 1.8 6.500e-08 0.0 6.992e-08 0.0 7.000e-08 1.8 7.492e-08 1.8 7.500e-08 1.8 7.992e-08 1.8 8.000e-08 1.8 8.492e-08 1.8 8.500e-08 0.0 8.992e-08 0.0 9.000e-08 0.0 9.492e-08 0.0 9.500e-08 1.8 9.992e-08 1.8 1.000e-07 1.8 1.049e-07 1.8 1.050e-07 1.8 1.099e-07 1.8 1.100e-07 1.8 1.149e-07 1.8 1.150e-07 1.8 1.199e-07 1.8 1.200e-07 1.8 1.249e-07 1.8 1.250e-07 0.0 1.299e-07 0.0 1.300e-07 0.0 1.349e-07 0.0 1.350e-07 0.0 1.399e-07 0.0 1.400e-07 1.8 1.449e-07 1.8 1.450e-07 0.0 1.499e-07 0.0 1.500e-07 0.0 1.549e-07 0.0 1.550e-07 0.0 1.599e-07 0.0 1.600e-07 1.8 1.649e-07 1.8 1.650e-07 0.0 1.699e-07 0.0 1.700e-07 0.0 1.749e-07 0.0 1.750e-07 0.0 1.799e-07 0.0 1.800e-07 1.8 1.849e-07 1.8 1.850e-07 0.0 1.899e-07 0.0 1.900e-07 0.0 1.949e-07 0.0 1.950e-07 0.0 1.999e-07 0.0 2.000e-07 1.8 2.049e-07 1.8 2.050e-07 1.8 2.099e-07 1.8 2.100e-07 1.8 2.149e-07 1.8 2.150e-07 1.8 2.199e-07 1.8 2.200e-07 1.8 2.249e-07 1.8 2.250e-07 1.8 2.299e-07 1.8 2.300e-07 0.0 2.349e-07 0.0 2.350e-07 0.0 2.399e-07 0.0 2.400e-07 1.8 2.449e-07 1.8 2.450e-07 1.8 2.499e-07 1.8 2.500e-07 1.8 2.549e-07 1.8 2.550e-07 0.0 2.599e-07 0.0 2.600e-07 1.8 2.649e-07 1.8 2.650e-07 0.0 2.699e-07 0.0 2.700e-07 1.8 2.749e-07 1.8 2.750e-07 0.0 2.799e-07 0.0 2.800e-07 1.8 2.849e-07 1.8 2.850e-07 0.0 2.899e-07 0.0 2.900e-07 0.0 2.949e-07 0.0 2.950e-07 1.8 2.999e-07 1.8 3.000e-07 0.0 3.049e-07 0.0 3.050e-07 0.0 3.099e-07 0.0 3.100e-07 0.0 3.149e-07 0.0 3.150e-07 1.8 3.199e-07 1.8 3.200e-07 0.0 3.249e-07 0.0 3.250e-07 0.0 3.299e-07 0.0 3.300e-07 1.8 3.349e-07 1.8 3.350e-07 1.8 3.399e-07 1.8 3.400e-07 1.8 3.449e-07 1.8 3.450e-07 0.0 3.499e-07 0.0 3.500e-07 1.8 3.549e-07 1.8 3.550e-07 1.8 3.599e-07 1.8 3.600e-07 0.0 3.649e-07 0.0 3.650e-07 1.8 3.699e-07 1.8 3.700e-07 0.0 3.749e-07 0.0 3.750e-07 1.8 3.799e-07 1.8 3.800e-07 0.0 3.849e-07 0.0 3.850e-07 1.8 3.899e-07 1.8 3.900e-07 0.0 3.949e-07 0.0 3.950e-07 0.0 3.999e-07 0.0 4.000e-07 0.0 4.049e-07 0.0 4.050e-07 1.8 4.099e-07 1.8 4.100e-07 1.8 4.149e-07 1.8 4.150e-07 0.0 4.199e-07 0.0 4.200e-07 0.0 4.249e-07 0.0 4.250e-07 0.0 4.299e-07 0.0 4.300e-07 0.0 4.349e-07 0.0 4.350e-07 0.0 4.399e-07 0.0 4.400e-07 0.0 4.449e-07 0.0 4.450e-07 1.8 4.499e-07 1.8 4.500e-07 1.8 4.549e-07 1.8 4.550e-07 1.8 4.599e-07 1.8 4.600e-07 0.0 4.649e-07 0.0 4.650e-07 1.8 4.699e-07 1.8 4.700e-07 1.8 4.749e-07 1.8 4.750e-07 1.8 4.799e-07 1.8 4.800e-07 0.0 4.849e-07 0.0 4.850e-07 1.8 4.899e-07 1.8 4.900e-07 1.8 4.949e-07 1.8 4.950e-07 1.8 4.999e-07 1.8 5.000e-07 0.0 5.049e-07 0.0 5.050e-07 1.8 5.099e-07 1.8 5.100e-07 1.8 5.149e-07 1.8 5.150e-07 1.8 5.199e-07 1.8 5.200e-07 0.0 5.249e-07 0.0 5.250e-07 0.0 5.299e-07 0.0 5.300e-07 0.0 5.349e-07 0.0 5.350e-07 0.0 5.399e-07 0.0 5.400e-07 0.0 5.449e-07 0.0 5.450e-07 0.0 5.499e-07 0.0 5.500e-07 1.8 5.549e-07 1.8 5.550e-07 1.8 5.599e-07 1.8 5.600e-07 0.0 5.649e-07 0.0 5.650e-07 0.0 5.699e-07 0.0 5.700e-07 0.0 5.749e-07 0.0 5.750e-07 1.8 5.799e-07 1.8 5.800e-07 0.0 5.849e-07 0.0 5.850e-07 1.8 5.899e-07 1.8 5.900e-07 0.0 5.949e-07 0.0 5.950e-07 1.8 5.999e-07 1.8 6.000e-07 0.0 6.049e-07 0.0 6.050e-07 1.8 6.099e-07 1.8 6.100e-07 1.8 6.149e-07 1.8 6.150e-07 0.0 6.199e-07 0.0 6.200e-07 1.8 6.249e-07 1.8 6.250e-07 1.8 6.299e-07 1.8 6.300e-07 1.8 6.349e-07 1.8 6.350e-07 0.0 6.399e-07 0.0 ]
V_DB1 (DB1 0) vsource type=pwl wave=[ 0.000e+00 1.8 4.920e-09 1.8 5.000e-09 0.0 9.920e-09 0.0 1.000e-08 1.8 1.492e-08 1.8 1.500e-08 1.8 1.992e-08 1.8 2.000e-08 1.8 2.492e-08 1.8 2.500e-08 0.0 2.992e-08 0.0 3.000e-08 1.8 3.492e-08 1.8 3.500e-08 1.8 3.992e-08 1.8 4.000e-08 0.0 4.492e-08 0.0 4.500e-08 1.8 4.992e-08 1.8 5.000e-08 0.0 5.492e-08 0.0 5.500e-08 1.8 5.992e-08 1.8 6.000e-08 0.0 6.492e-08 0.0 6.500e-08 1.8 6.992e-08 1.8 7.000e-08 0.0 7.492e-08 0.0 7.500e-08 0.0 7.992e-08 0.0 8.000e-08 0.0 8.492e-08 0.0 8.500e-08 1.8 8.992e-08 1.8 9.000e-08 1.8 9.492e-08 1.8 9.500e-08 0.0 9.992e-08 0.0 1.000e-07 0.0 1.049e-07 0.0 1.050e-07 0.0 1.099e-07 0.0 1.100e-07 0.0 1.149e-07 0.0 1.150e-07 0.0 1.199e-07 0.0 1.200e-07 0.0 1.249e-07 0.0 1.250e-07 1.8 1.299e-07 1.8 1.300e-07 1.8 1.349e-07 1.8 1.350e-07 1.8 1.399e-07 1.8 1.400e-07 0.0 1.449e-07 0.0 1.450e-07 1.8 1.499e-07 1.8 1.500e-07 1.8 1.549e-07 1.8 1.550e-07 1.8 1.599e-07 1.8 1.600e-07 0.0 1.649e-07 0.0 1.650e-07 1.8 1.699e-07 1.8 1.700e-07 1.8 1.749e-07 1.8 1.750e-07 1.8 1.799e-07 1.8 1.800e-07 0.0 1.849e-07 0.0 1.850e-07 1.8 1.899e-07 1.8 1.900e-07 1.8 1.949e-07 1.8 1.950e-07 1.8 1.999e-07 1.8 2.000e-07 0.0 2.049e-07 0.0 2.050e-07 0.0 2.099e-07 0.0 2.100e-07 0.0 2.149e-07 0.0 2.150e-07 0.0 2.199e-07 0.0 2.200e-07 0.0 2.249e-07 0.0 2.250e-07 0.0 2.299e-07 0.0 2.300e-07 1.8 2.349e-07 1.8 2.350e-07 1.8 2.399e-07 1.8 2.400e-07 0.0 2.449e-07 0.0 2.450e-07 0.0 2.499e-07 0.0 2.500e-07 0.0 2.549e-07 0.0 2.550e-07 1.8 2.599e-07 1.8 2.600e-07 0.0 2.649e-07 0.0 2.650e-07 1.8 2.699e-07 1.8 2.700e-07 0.0 2.749e-07 0.0 2.750e-07 1.8 2.799e-07 1.8 2.800e-07 0.0 2.849e-07 0.0 2.850e-07 1.8 2.899e-07 1.8 2.900e-07 1.8 2.949e-07 1.8 2.950e-07 0.0 2.999e-07 0.0 3.000e-07 1.8 3.049e-07 1.8 3.050e-07 1.8 3.099e-07 1.8 3.100e-07 1.8 3.149e-07 1.8 3.150e-07 0.0 3.199e-07 0.0 3.200e-07 1.8 3.249e-07 1.8 3.250e-07 1.8 3.299e-07 1.8 3.300e-07 0.0 3.349e-07 0.0 3.350e-07 0.0 3.399e-07 0.0 3.400e-07 0.0 3.449e-07 0.0 3.450e-07 1.8 3.499e-07 1.8 3.500e-07 0.0 3.549e-07 0.0 3.550e-07 0.0 3.599e-07 0.0 3.600e-07 1.8 3.649e-07 1.8 3.650e-07 0.0 3.699e-07 0.0 3.700e-07 1.8 3.749e-07 1.8 3.750e-07 0.0 3.799e-07 0.0 3.800e-07 1.8 3.849e-07 1.8 3.850e-07 0.0 3.899e-07 0.0 3.900e-07 1.8 3.949e-07 1.8 3.950e-07 1.8 3.999e-07 1.8 4.000e-07 1.8 4.049e-07 1.8 4.050e-07 0.0 4.099e-07 0.0 4.100e-07 0.0 4.149e-07 0.0 4.150e-07 1.8 4.199e-07 1.8 4.200e-07 1.8 4.249e-07 1.8 4.250e-07 1.8 4.299e-07 1.8 4.300e-07 1.8 4.349e-07 1.8 4.350e-07 1.8 4.399e-07 1.8 4.400e-07 1.8 4.449e-07 1.8 4.450e-07 0.0 4.499e-07 0.0 4.500e-07 0.0 4.549e-07 0.0 4.550e-07 0.0 4.599e-07 0.0 4.600e-07 1.8 4.649e-07 1.8 4.650e-07 0.0 4.699e-07 0.0 4.700e-07 0.0 4.749e-07 0.0 4.750e-07 0.0 4.799e-07 0.0 4.800e-07 1.8 4.849e-07 1.8 4.850e-07 0.0 4.899e-07 0.0 4.900e-07 0.0 4.949e-07 0.0 4.950e-07 0.0 4.999e-07 0.0 5.000e-07 1.8 5.049e-07 1.8 5.050e-07 0.0 5.099e-07 0.0 5.100e-07 0.0 5.149e-07 0.0 5.150e-07 0.0 5.199e-07 0.0 5.200e-07 1.8 5.249e-07 1.8 5.250e-07 1.8 5.299e-07 1.8 5.300e-07 1.8 5.349e-07 1.8 5.350e-07 1.8 5.399e-07 1.8 5.400e-07 1.8 5.449e-07 1.8 5.450e-07 1.8 5.499e-07 1.8 5.500e-07 0.0 5.549e-07 0.0 5.550e-07 0.0 5.599e-07 0.0 5.600e-07 1.8 5.649e-07 1.8 5.650e-07 1.8 5.699e-07 1.8 5.700e-07 1.8 5.749e-07 1.8 5.750e-07 0.0 5.799e-07 0.0 5.800e-07 1.8 5.849e-07 1.8 5.850e-07 0.0 5.899e-07 0.0 5.900e-07 1.8 5.949e-07 1.8 5.950e-07 0.0 5.999e-07 0.0 6.000e-07 1.8 6.049e-07 1.8 6.050e-07 0.0 6.099e-07 0.0 6.100e-07 0.0 6.149e-07 0.0 6.150e-07 1.8 6.199e-07 1.8 6.200e-07 0.0 6.249e-07 0.0 6.250e-07 0.0 6.299e-07 0.0 6.300e-07 0.0 6.349e-07 0.0 6.350e-07 1.8 6.399e-07 1.8 ]

V_D2 (D2 0) vsource type=pwl wave=[ 0.000e+00 0.0 4.920e-09 0.0 5.000e-09 0.0 9.920e-09 0.0 1.000e-08 1.8 1.492e-08 1.8 1.500e-08 1.8 1.992e-08 1.8 2.000e-08 0.0 2.492e-08 0.0 2.500e-08 1.8 2.992e-08 1.8 3.000e-08 1.8 3.492e-08 1.8 3.500e-08 0.0 3.992e-08 0.0 4.000e-08 0.0 4.492e-08 0.0 4.500e-08 0.0 4.992e-08 0.0 5.000e-08 0.0 5.492e-08 0.0 5.500e-08 1.8 5.992e-08 1.8 6.000e-08 1.8 6.492e-08 1.8 6.500e-08 1.8 6.992e-08 1.8 7.000e-08 1.8 7.492e-08 1.8 7.500e-08 0.0 7.992e-08 0.0 8.000e-08 0.0 8.492e-08 0.0 8.500e-08 0.0 8.992e-08 0.0 9.000e-08 1.8 9.492e-08 1.8 9.500e-08 0.0 9.992e-08 0.0 1.000e-07 1.8 1.049e-07 1.8 1.050e-07 1.8 1.099e-07 1.8 1.100e-07 1.8 1.149e-07 1.8 1.150e-07 0.0 1.199e-07 0.0 1.200e-07 0.0 1.249e-07 0.0 1.250e-07 0.0 1.299e-07 0.0 1.300e-07 0.0 1.349e-07 0.0 1.350e-07 0.0 1.399e-07 0.0 1.400e-07 1.8 1.449e-07 1.8 1.450e-07 1.8 1.499e-07 1.8 1.500e-07 0.0 1.549e-07 0.0 1.550e-07 0.0 1.599e-07 0.0 1.600e-07 1.8 1.649e-07 1.8 1.650e-07 0.0 1.699e-07 0.0 1.700e-07 0.0 1.749e-07 0.0 1.750e-07 1.8 1.799e-07 1.8 1.800e-07 1.8 1.849e-07 1.8 1.850e-07 0.0 1.899e-07 0.0 1.900e-07 0.0 1.949e-07 0.0 1.950e-07 0.0 1.999e-07 0.0 2.000e-07 0.0 2.049e-07 0.0 2.050e-07 0.0 2.099e-07 0.0 2.100e-07 1.8 2.149e-07 1.8 2.150e-07 1.8 2.199e-07 1.8 2.200e-07 1.8 2.249e-07 1.8 2.250e-07 0.0 2.299e-07 0.0 2.300e-07 1.8 2.349e-07 1.8 2.350e-07 0.0 2.399e-07 0.0 2.400e-07 0.0 2.449e-07 0.0 2.450e-07 0.0 2.499e-07 0.0 2.500e-07 1.8 2.549e-07 1.8 2.550e-07 1.8 2.599e-07 1.8 2.600e-07 1.8 2.649e-07 1.8 2.650e-07 1.8 2.699e-07 1.8 2.700e-07 0.0 2.749e-07 0.0 2.750e-07 0.0 2.799e-07 0.0 2.800e-07 0.0 2.849e-07 0.0 2.850e-07 0.0 2.899e-07 0.0 2.900e-07 1.8 2.949e-07 1.8 2.950e-07 1.8 2.999e-07 1.8 3.000e-07 0.0 3.049e-07 0.0 3.050e-07 1.8 3.099e-07 1.8 3.100e-07 1.8 3.149e-07 1.8 3.150e-07 0.0 3.199e-07 0.0 3.200e-07 0.0 3.249e-07 0.0 3.250e-07 1.8 3.299e-07 1.8 3.300e-07 0.0 3.349e-07 0.0 3.350e-07 0.0 3.399e-07 0.0 3.400e-07 1.8 3.449e-07 1.8 3.450e-07 0.0 3.499e-07 0.0 3.500e-07 0.0 3.549e-07 0.0 3.550e-07 1.8 3.599e-07 1.8 3.600e-07 1.8 3.649e-07 1.8 3.650e-07 1.8 3.699e-07 1.8 3.700e-07 1.8 3.749e-07 1.8 3.750e-07 0.0 3.799e-07 0.0 3.800e-07 0.0 3.849e-07 0.0 3.850e-07 0.0 3.899e-07 0.0 3.900e-07 0.0 3.949e-07 0.0 3.950e-07 1.8 3.999e-07 1.8 4.000e-07 1.8 4.049e-07 1.8 4.050e-07 1.8 4.099e-07 1.8 4.100e-07 0.0 4.149e-07 0.0 4.150e-07 1.8 4.199e-07 1.8 4.200e-07 0.0 4.249e-07 0.0 4.250e-07 0.0 4.299e-07 0.0 4.300e-07 0.0 4.349e-07 0.0 4.350e-07 1.8 4.399e-07 1.8 4.400e-07 1.8 4.449e-07 1.8 4.450e-07 1.8 4.499e-07 1.8 4.500e-07 1.8 4.549e-07 1.8 4.550e-07 1.8 4.599e-07 1.8 4.600e-07 0.0 4.649e-07 0.0 4.650e-07 0.0 4.699e-07 0.0 4.700e-07 1.8 4.749e-07 1.8 4.750e-07 1.8 4.799e-07 1.8 4.800e-07 0.0 4.849e-07 0.0 4.850e-07 1.8 4.899e-07 1.8 4.900e-07 1.8 4.949e-07 1.8 4.950e-07 0.0 4.999e-07 0.0 5.000e-07 0.0 5.049e-07 0.0 5.050e-07 1.8 5.099e-07 1.8 5.100e-07 1.8 5.149e-07 1.8 5.150e-07 1.8 5.199e-07 1.8 5.200e-07 1.8 5.249e-07 1.8 5.250e-07 1.8 5.299e-07 1.8 5.300e-07 0.0 5.349e-07 0.0 5.350e-07 0.0 5.399e-07 0.0 5.400e-07 0.0 5.449e-07 0.0 5.450e-07 1.8 5.499e-07 1.8 5.500e-07 0.0 5.549e-07 0.0 5.550e-07 1.8 5.599e-07 1.8 5.600e-07 1.8 5.649e-07 1.8 5.650e-07 1.8 5.699e-07 1.8 5.700e-07 0.0 5.749e-07 0.0 5.750e-07 0.0 5.799e-07 0.0 5.800e-07 0.0 5.849e-07 0.0 5.850e-07 0.0 5.899e-07 0.0 5.900e-07 1.8 5.949e-07 1.8 5.950e-07 1.8 5.999e-07 1.8 6.000e-07 1.8 6.049e-07 1.8 6.050e-07 1.8 6.099e-07 1.8 6.100e-07 0.0 6.149e-07 0.0 6.150e-07 0.0 6.199e-07 0.0 6.200e-07 1.8 6.249e-07 1.8 6.250e-07 0.0 6.299e-07 0.0 6.300e-07 0.0 6.349e-07 0.0 6.350e-07 1.8 6.399e-07 1.8 ]
V_DB2 (DB2 0) vsource type=pwl wave=[ 0.000e+00 1.8 4.920e-09 1.8 5.000e-09 1.8 9.920e-09 1.8 1.000e-08 0.0 1.492e-08 0.0 1.500e-08 0.0 1.992e-08 0.0 2.000e-08 1.8 2.492e-08 1.8 2.500e-08 0.0 2.992e-08 0.0 3.000e-08 0.0 3.492e-08 0.0 3.500e-08 1.8 3.992e-08 1.8 4.000e-08 1.8 4.492e-08 1.8 4.500e-08 1.8 4.992e-08 1.8 5.000e-08 1.8 5.492e-08 1.8 5.500e-08 0.0 5.992e-08 0.0 6.000e-08 0.0 6.492e-08 0.0 6.500e-08 0.0 6.992e-08 0.0 7.000e-08 0.0 7.492e-08 0.0 7.500e-08 1.8 7.992e-08 1.8 8.000e-08 1.8 8.492e-08 1.8 8.500e-08 1.8 8.992e-08 1.8 9.000e-08 0.0 9.492e-08 0.0 9.500e-08 1.8 9.992e-08 1.8 1.000e-07 0.0 1.049e-07 0.0 1.050e-07 0.0 1.099e-07 0.0 1.100e-07 0.0 1.149e-07 0.0 1.150e-07 1.8 1.199e-07 1.8 1.200e-07 1.8 1.249e-07 1.8 1.250e-07 1.8 1.299e-07 1.8 1.300e-07 1.8 1.349e-07 1.8 1.350e-07 1.8 1.399e-07 1.8 1.400e-07 0.0 1.449e-07 0.0 1.450e-07 0.0 1.499e-07 0.0 1.500e-07 1.8 1.549e-07 1.8 1.550e-07 1.8 1.599e-07 1.8 1.600e-07 0.0 1.649e-07 0.0 1.650e-07 1.8 1.699e-07 1.8 1.700e-07 1.8 1.749e-07 1.8 1.750e-07 0.0 1.799e-07 0.0 1.800e-07 0.0 1.849e-07 0.0 1.850e-07 1.8 1.899e-07 1.8 1.900e-07 1.8 1.949e-07 1.8 1.950e-07 1.8 1.999e-07 1.8 2.000e-07 1.8 2.049e-07 1.8 2.050e-07 1.8 2.099e-07 1.8 2.100e-07 0.0 2.149e-07 0.0 2.150e-07 0.0 2.199e-07 0.0 2.200e-07 0.0 2.249e-07 0.0 2.250e-07 1.8 2.299e-07 1.8 2.300e-07 0.0 2.349e-07 0.0 2.350e-07 1.8 2.399e-07 1.8 2.400e-07 1.8 2.449e-07 1.8 2.450e-07 1.8 2.499e-07 1.8 2.500e-07 0.0 2.549e-07 0.0 2.550e-07 0.0 2.599e-07 0.0 2.600e-07 0.0 2.649e-07 0.0 2.650e-07 0.0 2.699e-07 0.0 2.700e-07 1.8 2.749e-07 1.8 2.750e-07 1.8 2.799e-07 1.8 2.800e-07 1.8 2.849e-07 1.8 2.850e-07 1.8 2.899e-07 1.8 2.900e-07 0.0 2.949e-07 0.0 2.950e-07 0.0 2.999e-07 0.0 3.000e-07 1.8 3.049e-07 1.8 3.050e-07 0.0 3.099e-07 0.0 3.100e-07 0.0 3.149e-07 0.0 3.150e-07 1.8 3.199e-07 1.8 3.200e-07 1.8 3.249e-07 1.8 3.250e-07 0.0 3.299e-07 0.0 3.300e-07 1.8 3.349e-07 1.8 3.350e-07 1.8 3.399e-07 1.8 3.400e-07 0.0 3.449e-07 0.0 3.450e-07 1.8 3.499e-07 1.8 3.500e-07 1.8 3.549e-07 1.8 3.550e-07 0.0 3.599e-07 0.0 3.600e-07 0.0 3.649e-07 0.0 3.650e-07 0.0 3.699e-07 0.0 3.700e-07 0.0 3.749e-07 0.0 3.750e-07 1.8 3.799e-07 1.8 3.800e-07 1.8 3.849e-07 1.8 3.850e-07 1.8 3.899e-07 1.8 3.900e-07 1.8 3.949e-07 1.8 3.950e-07 0.0 3.999e-07 0.0 4.000e-07 0.0 4.049e-07 0.0 4.050e-07 0.0 4.099e-07 0.0 4.100e-07 1.8 4.149e-07 1.8 4.150e-07 0.0 4.199e-07 0.0 4.200e-07 1.8 4.249e-07 1.8 4.250e-07 1.8 4.299e-07 1.8 4.300e-07 1.8 4.349e-07 1.8 4.350e-07 0.0 4.399e-07 0.0 4.400e-07 0.0 4.449e-07 0.0 4.450e-07 0.0 4.499e-07 0.0 4.500e-07 0.0 4.549e-07 0.0 4.550e-07 0.0 4.599e-07 0.0 4.600e-07 1.8 4.649e-07 1.8 4.650e-07 1.8 4.699e-07 1.8 4.700e-07 0.0 4.749e-07 0.0 4.750e-07 0.0 4.799e-07 0.0 4.800e-07 1.8 4.849e-07 1.8 4.850e-07 0.0 4.899e-07 0.0 4.900e-07 0.0 4.949e-07 0.0 4.950e-07 1.8 4.999e-07 1.8 5.000e-07 1.8 5.049e-07 1.8 5.050e-07 0.0 5.099e-07 0.0 5.100e-07 0.0 5.149e-07 0.0 5.150e-07 0.0 5.199e-07 0.0 5.200e-07 0.0 5.249e-07 0.0 5.250e-07 0.0 5.299e-07 0.0 5.300e-07 1.8 5.349e-07 1.8 5.350e-07 1.8 5.399e-07 1.8 5.400e-07 1.8 5.449e-07 1.8 5.450e-07 0.0 5.499e-07 0.0 5.500e-07 1.8 5.549e-07 1.8 5.550e-07 0.0 5.599e-07 0.0 5.600e-07 0.0 5.649e-07 0.0 5.650e-07 0.0 5.699e-07 0.0 5.700e-07 1.8 5.749e-07 1.8 5.750e-07 1.8 5.799e-07 1.8 5.800e-07 1.8 5.849e-07 1.8 5.850e-07 1.8 5.899e-07 1.8 5.900e-07 0.0 5.949e-07 0.0 5.950e-07 0.0 5.999e-07 0.0 6.000e-07 0.0 6.049e-07 0.0 6.050e-07 0.0 6.099e-07 0.0 6.100e-07 1.8 6.149e-07 1.8 6.150e-07 1.8 6.199e-07 1.8 6.200e-07 0.0 6.249e-07 0.0 6.250e-07 1.8 6.299e-07 1.8 6.300e-07 1.8 6.349e-07 1.8 6.350e-07 0.0 6.399e-07 0.0 ]

V_D3 (D3 0) vsource type=pwl wave=[ 0.000e+00 0.0 4.920e-09 0.0 5.000e-09 0.0 9.920e-09 0.0 1.000e-08 1.8 1.492e-08 1.8 1.500e-08 1.8 1.992e-08 1.8 2.000e-08 0.0 2.492e-08 0.0 2.500e-08 1.8 2.992e-08 1.8 3.000e-08 1.8 3.492e-08 1.8 3.500e-08 0.0 3.992e-08 0.0 4.000e-08 0.0 4.492e-08 0.0 4.500e-08 0.0 4.992e-08 0.0 5.000e-08 0.0 5.492e-08 0.0 5.500e-08 0.0 5.992e-08 0.0 6.000e-08 1.8 6.492e-08 1.8 6.500e-08 1.8 6.992e-08 1.8 7.000e-08 1.8 7.492e-08 1.8 7.500e-08 1.8 7.992e-08 1.8 8.000e-08 1.8 8.492e-08 1.8 8.500e-08 0.0 8.992e-08 0.0 9.000e-08 0.0 9.492e-08 0.0 9.500e-08 0.0 9.992e-08 0.0 1.000e-07 0.0 1.049e-07 0.0 1.050e-07 0.0 1.099e-07 0.0 1.100e-07 1.8 1.149e-07 1.8 1.150e-07 1.8 1.199e-07 1.8 1.200e-07 1.8 1.249e-07 1.8 1.250e-07 1.8 1.299e-07 1.8 1.300e-07 1.8 1.349e-07 1.8 1.350e-07 0.0 1.399e-07 0.0 1.400e-07 0.0 1.449e-07 0.0 1.450e-07 0.0 1.499e-07 0.0 1.500e-07 1.8 1.549e-07 1.8 1.550e-07 1.8 1.599e-07 1.8 1.600e-07 1.8 1.649e-07 1.8 1.650e-07 1.8 1.699e-07 1.8 1.700e-07 1.8 1.749e-07 1.8 1.750e-07 0.0 1.799e-07 0.0 1.800e-07 0.0 1.849e-07 0.0 1.850e-07 0.0 1.899e-07 0.0 1.900e-07 1.8 1.949e-07 1.8 1.950e-07 1.8 1.999e-07 1.8 2.000e-07 1.8 2.049e-07 1.8 2.050e-07 1.8 2.099e-07 1.8 2.100e-07 1.8 2.149e-07 1.8 2.150e-07 0.0 2.199e-07 0.0 2.200e-07 0.0 2.249e-07 0.0 2.250e-07 0.0 2.299e-07 0.0 2.300e-07 0.0 2.349e-07 0.0 2.350e-07 0.0 2.399e-07 0.0 2.400e-07 1.8 2.449e-07 1.8 2.450e-07 1.8 2.499e-07 1.8 2.500e-07 1.8 2.549e-07 1.8 2.550e-07 1.8 2.599e-07 1.8 2.600e-07 1.8 2.649e-07 1.8 2.650e-07 0.0 2.699e-07 0.0 2.700e-07 0.0 2.749e-07 0.0 2.750e-07 0.0 2.799e-07 0.0 2.800e-07 0.0 2.849e-07 0.0 2.850e-07 0.0 2.899e-07 0.0 2.900e-07 1.8 2.949e-07 1.8 2.950e-07 1.8 2.999e-07 1.8 3.000e-07 0.0 3.049e-07 0.0 3.050e-07 1.8 3.099e-07 1.8 3.100e-07 1.8 3.149e-07 1.8 3.150e-07 0.0 3.199e-07 0.0 3.200e-07 0.0 3.249e-07 0.0 3.250e-07 1.8 3.299e-07 1.8 3.300e-07 0.0 3.349e-07 0.0 3.350e-07 0.0 3.399e-07 0.0 3.400e-07 1.8 3.449e-07 1.8 3.450e-07 0.0 3.499e-07 0.0 3.500e-07 0.0 3.549e-07 0.0 3.550e-07 1.8 3.599e-07 1.8 3.600e-07 1.8 3.649e-07 1.8 3.650e-07 1.8 3.699e-07 1.8 3.700e-07 1.8 3.749e-07 1.8 3.750e-07 1.8 3.799e-07 1.8 3.800e-07 0.0 3.849e-07 0.0 3.850e-07 0.0 3.899e-07 0.0 3.900e-07 0.0 3.949e-07 0.0 3.950e-07 0.0 3.999e-07 0.0 4.000e-07 0.0 4.049e-07 0.0 4.050e-07 1.8 4.099e-07 1.8 4.100e-07 1.8 4.149e-07 1.8 4.150e-07 1.8 4.199e-07 1.8 4.200e-07 1.8 4.249e-07 1.8 4.250e-07 1.8 4.299e-07 1.8 4.300e-07 0.0 4.349e-07 0.0 4.350e-07 0.0 4.399e-07 0.0 4.400e-07 0.0 4.449e-07 0.0 4.450e-07 0.0 4.499e-07 0.0 4.500e-07 0.0 4.549e-07 0.0 4.550e-07 1.8 4.599e-07 1.8 4.600e-07 1.8 4.649e-07 1.8 4.650e-07 1.8 4.699e-07 1.8 4.700e-07 0.0 4.749e-07 0.0 4.750e-07 0.0 4.799e-07 0.0 4.800e-07 0.0 4.849e-07 0.0 4.850e-07 0.0 4.899e-07 0.0 4.900e-07 0.0 4.949e-07 0.0 4.950e-07 1.8 4.999e-07 1.8 5.000e-07 1.8 5.049e-07 1.8 5.050e-07 1.8 5.099e-07 1.8 5.100e-07 0.0 5.149e-07 0.0 5.150e-07 0.0 5.199e-07 0.0 5.200e-07 0.0 5.249e-07 0.0 5.250e-07 0.0 5.299e-07 0.0 5.300e-07 0.0 5.349e-07 0.0 5.350e-07 1.8 5.399e-07 1.8 5.400e-07 1.8 5.449e-07 1.8 5.450e-07 1.8 5.499e-07 1.8 5.500e-07 1.8 5.549e-07 1.8 5.550e-07 1.8 5.599e-07 1.8 5.600e-07 0.0 5.649e-07 0.0 5.650e-07 0.0 5.699e-07 0.0 5.700e-07 0.0 5.749e-07 0.0 5.750e-07 0.0 5.799e-07 0.0 5.800e-07 0.0 5.849e-07 0.0 5.850e-07 1.8 5.899e-07 1.8 5.900e-07 1.8 5.949e-07 1.8 5.950e-07 1.8 5.999e-07 1.8 6.000e-07 1.8 6.049e-07 1.8 6.050e-07 1.8 6.099e-07 1.8 6.100e-07 0.0 6.149e-07 0.0 6.150e-07 0.0 6.199e-07 0.0 6.200e-07 1.8 6.249e-07 1.8 6.250e-07 0.0 6.299e-07 0.0 6.300e-07 0.0 6.349e-07 0.0 6.350e-07 1.8 6.399e-07 1.8 ]
V_DB3 (DB3 0) vsource type=pwl wave=[ 0.000e+00 1.8 4.920e-09 1.8 5.000e-09 1.8 9.920e-09 1.8 1.000e-08 0.0 1.492e-08 0.0 1.500e-08 0.0 1.992e-08 0.0 2.000e-08 1.8 2.492e-08 1.8 2.500e-08 0.0 2.992e-08 0.0 3.000e-08 0.0 3.492e-08 0.0 3.500e-08 1.8 3.992e-08 1.8 4.000e-08 1.8 4.492e-08 1.8 4.500e-08 1.8 4.992e-08 1.8 5.000e-08 1.8 5.492e-08 1.8 5.500e-08 1.8 5.992e-08 1.8 6.000e-08 0.0 6.492e-08 0.0 6.500e-08 0.0 6.992e-08 0.0 7.000e-08 0.0 7.492e-08 0.0 7.500e-08 0.0 7.992e-08 0.0 8.000e-08 0.0 8.492e-08 0.0 8.500e-08 1.8 8.992e-08 1.8 9.000e-08 1.8 9.492e-08 1.8 9.500e-08 1.8 9.992e-08 1.8 1.000e-07 1.8 1.049e-07 1.8 1.050e-07 1.8 1.099e-07 1.8 1.100e-07 0.0 1.149e-07 0.0 1.150e-07 0.0 1.199e-07 0.0 1.200e-07 0.0 1.249e-07 0.0 1.250e-07 0.0 1.299e-07 0.0 1.300e-07 0.0 1.349e-07 0.0 1.350e-07 1.8 1.399e-07 1.8 1.400e-07 1.8 1.449e-07 1.8 1.450e-07 1.8 1.499e-07 1.8 1.500e-07 0.0 1.549e-07 0.0 1.550e-07 0.0 1.599e-07 0.0 1.600e-07 0.0 1.649e-07 0.0 1.650e-07 0.0 1.699e-07 0.0 1.700e-07 0.0 1.749e-07 0.0 1.750e-07 1.8 1.799e-07 1.8 1.800e-07 1.8 1.849e-07 1.8 1.850e-07 1.8 1.899e-07 1.8 1.900e-07 0.0 1.949e-07 0.0 1.950e-07 0.0 1.999e-07 0.0 2.000e-07 0.0 2.049e-07 0.0 2.050e-07 0.0 2.099e-07 0.0 2.100e-07 0.0 2.149e-07 0.0 2.150e-07 1.8 2.199e-07 1.8 2.200e-07 1.8 2.249e-07 1.8 2.250e-07 1.8 2.299e-07 1.8 2.300e-07 1.8 2.349e-07 1.8 2.350e-07 1.8 2.399e-07 1.8 2.400e-07 0.0 2.449e-07 0.0 2.450e-07 0.0 2.499e-07 0.0 2.500e-07 0.0 2.549e-07 0.0 2.550e-07 0.0 2.599e-07 0.0 2.600e-07 0.0 2.649e-07 0.0 2.650e-07 1.8 2.699e-07 1.8 2.700e-07 1.8 2.749e-07 1.8 2.750e-07 1.8 2.799e-07 1.8 2.800e-07 1.8 2.849e-07 1.8 2.850e-07 1.8 2.899e-07 1.8 2.900e-07 0.0 2.949e-07 0.0 2.950e-07 0.0 2.999e-07 0.0 3.000e-07 1.8 3.049e-07 1.8 3.050e-07 0.0 3.099e-07 0.0 3.100e-07 0.0 3.149e-07 0.0 3.150e-07 1.8 3.199e-07 1.8 3.200e-07 1.8 3.249e-07 1.8 3.250e-07 0.0 3.299e-07 0.0 3.300e-07 1.8 3.349e-07 1.8 3.350e-07 1.8 3.399e-07 1.8 3.400e-07 0.0 3.449e-07 0.0 3.450e-07 1.8 3.499e-07 1.8 3.500e-07 1.8 3.549e-07 1.8 3.550e-07 0.0 3.599e-07 0.0 3.600e-07 0.0 3.649e-07 0.0 3.650e-07 0.0 3.699e-07 0.0 3.700e-07 0.0 3.749e-07 0.0 3.750e-07 0.0 3.799e-07 0.0 3.800e-07 1.8 3.849e-07 1.8 3.850e-07 1.8 3.899e-07 1.8 3.900e-07 1.8 3.949e-07 1.8 3.950e-07 1.8 3.999e-07 1.8 4.000e-07 1.8 4.049e-07 1.8 4.050e-07 0.0 4.099e-07 0.0 4.100e-07 0.0 4.149e-07 0.0 4.150e-07 0.0 4.199e-07 0.0 4.200e-07 0.0 4.249e-07 0.0 4.250e-07 0.0 4.299e-07 0.0 4.300e-07 1.8 4.349e-07 1.8 4.350e-07 1.8 4.399e-07 1.8 4.400e-07 1.8 4.449e-07 1.8 4.450e-07 1.8 4.499e-07 1.8 4.500e-07 1.8 4.549e-07 1.8 4.550e-07 0.0 4.599e-07 0.0 4.600e-07 0.0 4.649e-07 0.0 4.650e-07 0.0 4.699e-07 0.0 4.700e-07 1.8 4.749e-07 1.8 4.750e-07 1.8 4.799e-07 1.8 4.800e-07 1.8 4.849e-07 1.8 4.850e-07 1.8 4.899e-07 1.8 4.900e-07 1.8 4.949e-07 1.8 4.950e-07 0.0 4.999e-07 0.0 5.000e-07 0.0 5.049e-07 0.0 5.050e-07 0.0 5.099e-07 0.0 5.100e-07 1.8 5.149e-07 1.8 5.150e-07 1.8 5.199e-07 1.8 5.200e-07 1.8 5.249e-07 1.8 5.250e-07 1.8 5.299e-07 1.8 5.300e-07 1.8 5.349e-07 1.8 5.350e-07 0.0 5.399e-07 0.0 5.400e-07 0.0 5.449e-07 0.0 5.450e-07 0.0 5.499e-07 0.0 5.500e-07 0.0 5.549e-07 0.0 5.550e-07 0.0 5.599e-07 0.0 5.600e-07 1.8 5.649e-07 1.8 5.650e-07 1.8 5.699e-07 1.8 5.700e-07 1.8 5.749e-07 1.8 5.750e-07 1.8 5.799e-07 1.8 5.800e-07 1.8 5.849e-07 1.8 5.850e-07 0.0 5.899e-07 0.0 5.900e-07 0.0 5.949e-07 0.0 5.950e-07 0.0 5.999e-07 0.0 6.000e-07 0.0 6.049e-07 0.0 6.050e-07 0.0 6.099e-07 0.0 6.100e-07 1.8 6.149e-07 1.8 6.150e-07 1.8 6.199e-07 1.8 6.200e-07 0.0 6.249e-07 0.0 6.250e-07 1.8 6.299e-07 1.8 6.300e-07 1.8 6.349e-07 1.8 6.350e-07 0.0 6.399e-07 0.0 ]

V_D4 (D4 0) vsource type=pwl wave=[ 0.000e+00 0.0 4.920e-09 0.0 5.000e-09 1.8 9.920e-09 1.8 1.000e-08 1.8 1.492e-08 1.8 1.500e-08 1.8 1.992e-08 1.8 2.000e-08 1.8 2.492e-08 1.8 2.500e-08 1.8 2.992e-08 1.8 3.000e-08 0.0 3.492e-08 0.0 3.500e-08 0.0 3.992e-08 0.0 4.000e-08 0.0 4.492e-08 0.0 4.500e-08 1.8 4.992e-08 1.8 5.000e-08 0.0 5.492e-08 0.0 5.500e-08 1.8 5.992e-08 1.8 6.000e-08 1.8 6.492e-08 1.8 6.500e-08 1.8 6.992e-08 1.8 7.000e-08 0.0 7.492e-08 0.0 7.500e-08 1.8 7.992e-08 1.8 8.000e-08 0.0 8.492e-08 0.0 8.500e-08 0.0 8.992e-08 0.0 9.000e-08 0.0 9.492e-08 0.0 9.500e-08 1.8 9.992e-08 1.8 1.000e-07 0.0 1.049e-07 0.0 1.050e-07 1.8 1.099e-07 1.8 1.100e-07 1.8 1.149e-07 1.8 1.150e-07 1.8 1.199e-07 1.8 1.200e-07 0.0 1.249e-07 0.0 1.250e-07 1.8 1.299e-07 1.8 1.300e-07 0.0 1.349e-07 0.0 1.350e-07 0.0 1.399e-07 0.0 1.400e-07 0.0 1.449e-07 0.0 1.450e-07 1.8 1.499e-07 1.8 1.500e-07 0.0 1.549e-07 0.0 1.550e-07 1.8 1.599e-07 1.8 1.600e-07 1.8 1.649e-07 1.8 1.650e-07 1.8 1.699e-07 1.8 1.700e-07 0.0 1.749e-07 0.0 1.750e-07 1.8 1.799e-07 1.8 1.800e-07 0.0 1.849e-07 0.0 1.850e-07 0.0 1.899e-07 0.0 1.900e-07 0.0 1.949e-07 0.0 1.950e-07 1.8 1.999e-07 1.8 2.000e-07 0.0 2.049e-07 0.0 2.050e-07 1.8 2.099e-07 1.8 2.100e-07 1.8 2.149e-07 1.8 2.150e-07 1.8 2.199e-07 1.8 2.200e-07 0.0 2.249e-07 0.0 2.250e-07 1.8 2.299e-07 1.8 2.300e-07 0.0 2.349e-07 0.0 2.350e-07 0.0 2.399e-07 0.0 2.400e-07 0.0 2.449e-07 0.0 2.450e-07 1.8 2.499e-07 1.8 2.500e-07 0.0 2.549e-07 0.0 2.550e-07 1.8 2.599e-07 1.8 2.600e-07 1.8 2.649e-07 1.8 2.650e-07 1.8 2.699e-07 1.8 2.700e-07 0.0 2.749e-07 0.0 2.750e-07 1.8 2.799e-07 1.8 2.800e-07 0.0 2.849e-07 0.0 2.850e-07 0.0 2.899e-07 0.0 2.900e-07 0.0 2.949e-07 0.0 2.950e-07 1.8 2.999e-07 1.8 3.000e-07 1.8 3.049e-07 1.8 3.050e-07 1.8 3.099e-07 1.8 3.100e-07 1.8 3.149e-07 1.8 3.150e-07 1.8 3.199e-07 1.8 3.200e-07 0.0 3.249e-07 0.0 3.250e-07 0.0 3.299e-07 0.0 3.300e-07 0.0 3.349e-07 0.0 3.350e-07 0.0 3.399e-07 0.0 3.400e-07 0.0 3.449e-07 0.0 3.450e-07 0.0 3.499e-07 0.0 3.500e-07 1.8 3.549e-07 1.8 3.550e-07 1.8 3.599e-07 1.8 3.600e-07 1.8 3.649e-07 1.8 3.650e-07 0.0 3.699e-07 0.0 3.700e-07 1.8 3.749e-07 1.8 3.750e-07 0.0 3.799e-07 0.0 3.800e-07 0.0 3.849e-07 0.0 3.850e-07 0.0 3.899e-07 0.0 3.900e-07 1.8 3.949e-07 1.8 3.950e-07 0.0 3.999e-07 0.0 4.000e-07 1.8 4.049e-07 1.8 4.050e-07 1.8 4.099e-07 1.8 4.100e-07 1.8 4.149e-07 1.8 4.150e-07 0.0 4.199e-07 0.0 4.200e-07 1.8 4.249e-07 1.8 4.250e-07 0.0 4.299e-07 0.0 4.300e-07 0.0 4.349e-07 0.0 4.350e-07 0.0 4.399e-07 0.0 4.400e-07 1.8 4.449e-07 1.8 4.450e-07 0.0 4.499e-07 0.0 4.500e-07 1.8 4.549e-07 1.8 4.550e-07 1.8 4.599e-07 1.8 4.600e-07 1.8 4.649e-07 1.8 4.650e-07 0.0 4.699e-07 0.0 4.700e-07 1.8 4.749e-07 1.8 4.750e-07 0.0 4.799e-07 0.0 4.800e-07 0.0 4.849e-07 0.0 4.850e-07 0.0 4.899e-07 0.0 4.900e-07 1.8 4.949e-07 1.8 4.950e-07 0.0 4.999e-07 0.0 5.000e-07 1.8 5.049e-07 1.8 5.050e-07 1.8 5.099e-07 1.8 5.100e-07 1.8 5.149e-07 1.8 5.150e-07 0.0 5.199e-07 0.0 5.200e-07 1.8 5.249e-07 1.8 5.250e-07 0.0 5.299e-07 0.0 5.300e-07 0.0 5.349e-07 0.0 5.350e-07 0.0 5.399e-07 0.0 5.400e-07 1.8 5.449e-07 1.8 5.450e-07 0.0 5.499e-07 0.0 5.500e-07 1.8 5.549e-07 1.8 5.550e-07 1.8 5.599e-07 1.8 5.600e-07 1.8 5.649e-07 1.8 5.650e-07 0.0 5.699e-07 0.0 5.700e-07 1.8 5.749e-07 1.8 5.750e-07 0.0 5.799e-07 0.0 5.800e-07 0.0 5.849e-07 0.0 5.850e-07 0.0 5.899e-07 0.0 5.900e-07 1.8 5.949e-07 1.8 5.950e-07 0.0 5.999e-07 0.0 6.000e-07 1.8 6.049e-07 1.8 6.050e-07 1.8 6.099e-07 1.8 6.100e-07 1.8 6.149e-07 1.8 6.150e-07 0.0 6.199e-07 0.0 6.200e-07 0.0 6.249e-07 0.0 6.250e-07 0.0 6.299e-07 0.0 6.300e-07 0.0 6.349e-07 0.0 6.350e-07 0.0 6.399e-07 0.0 ]
V_DB4 (DB4 0) vsource type=pwl wave=[ 0.000e+00 1.8 4.920e-09 1.8 5.000e-09 0.0 9.920e-09 0.0 1.000e-08 0.0 1.492e-08 0.0 1.500e-08 0.0 1.992e-08 0.0 2.000e-08 0.0 2.492e-08 0.0 2.500e-08 0.0 2.992e-08 0.0 3.000e-08 1.8 3.492e-08 1.8 3.500e-08 1.8 3.992e-08 1.8 4.000e-08 1.8 4.492e-08 1.8 4.500e-08 0.0 4.992e-08 0.0 5.000e-08 1.8 5.492e-08 1.8 5.500e-08 0.0 5.992e-08 0.0 6.000e-08 0.0 6.492e-08 0.0 6.500e-08 0.0 6.992e-08 0.0 7.000e-08 1.8 7.492e-08 1.8 7.500e-08 0.0 7.992e-08 0.0 8.000e-08 1.8 8.492e-08 1.8 8.500e-08 1.8 8.992e-08 1.8 9.000e-08 1.8 9.492e-08 1.8 9.500e-08 0.0 9.992e-08 0.0 1.000e-07 1.8 1.049e-07 1.8 1.050e-07 0.0 1.099e-07 0.0 1.100e-07 0.0 1.149e-07 0.0 1.150e-07 0.0 1.199e-07 0.0 1.200e-07 1.8 1.249e-07 1.8 1.250e-07 0.0 1.299e-07 0.0 1.300e-07 1.8 1.349e-07 1.8 1.350e-07 1.8 1.399e-07 1.8 1.400e-07 1.8 1.449e-07 1.8 1.450e-07 0.0 1.499e-07 0.0 1.500e-07 1.8 1.549e-07 1.8 1.550e-07 0.0 1.599e-07 0.0 1.600e-07 0.0 1.649e-07 0.0 1.650e-07 0.0 1.699e-07 0.0 1.700e-07 1.8 1.749e-07 1.8 1.750e-07 0.0 1.799e-07 0.0 1.800e-07 1.8 1.849e-07 1.8 1.850e-07 1.8 1.899e-07 1.8 1.900e-07 1.8 1.949e-07 1.8 1.950e-07 0.0 1.999e-07 0.0 2.000e-07 1.8 2.049e-07 1.8 2.050e-07 0.0 2.099e-07 0.0 2.100e-07 0.0 2.149e-07 0.0 2.150e-07 0.0 2.199e-07 0.0 2.200e-07 1.8 2.249e-07 1.8 2.250e-07 0.0 2.299e-07 0.0 2.300e-07 1.8 2.349e-07 1.8 2.350e-07 1.8 2.399e-07 1.8 2.400e-07 1.8 2.449e-07 1.8 2.450e-07 0.0 2.499e-07 0.0 2.500e-07 1.8 2.549e-07 1.8 2.550e-07 0.0 2.599e-07 0.0 2.600e-07 0.0 2.649e-07 0.0 2.650e-07 0.0 2.699e-07 0.0 2.700e-07 1.8 2.749e-07 1.8 2.750e-07 0.0 2.799e-07 0.0 2.800e-07 1.8 2.849e-07 1.8 2.850e-07 1.8 2.899e-07 1.8 2.900e-07 1.8 2.949e-07 1.8 2.950e-07 0.0 2.999e-07 0.0 3.000e-07 0.0 3.049e-07 0.0 3.050e-07 0.0 3.099e-07 0.0 3.100e-07 0.0 3.149e-07 0.0 3.150e-07 0.0 3.199e-07 0.0 3.200e-07 1.8 3.249e-07 1.8 3.250e-07 1.8 3.299e-07 1.8 3.300e-07 1.8 3.349e-07 1.8 3.350e-07 1.8 3.399e-07 1.8 3.400e-07 1.8 3.449e-07 1.8 3.450e-07 1.8 3.499e-07 1.8 3.500e-07 0.0 3.549e-07 0.0 3.550e-07 0.0 3.599e-07 0.0 3.600e-07 0.0 3.649e-07 0.0 3.650e-07 1.8 3.699e-07 1.8 3.700e-07 0.0 3.749e-07 0.0 3.750e-07 1.8 3.799e-07 1.8 3.800e-07 1.8 3.849e-07 1.8 3.850e-07 1.8 3.899e-07 1.8 3.900e-07 0.0 3.949e-07 0.0 3.950e-07 1.8 3.999e-07 1.8 4.000e-07 0.0 4.049e-07 0.0 4.050e-07 0.0 4.099e-07 0.0 4.100e-07 0.0 4.149e-07 0.0 4.150e-07 1.8 4.199e-07 1.8 4.200e-07 0.0 4.249e-07 0.0 4.250e-07 1.8 4.299e-07 1.8 4.300e-07 1.8 4.349e-07 1.8 4.350e-07 1.8 4.399e-07 1.8 4.400e-07 0.0 4.449e-07 0.0 4.450e-07 1.8 4.499e-07 1.8 4.500e-07 0.0 4.549e-07 0.0 4.550e-07 0.0 4.599e-07 0.0 4.600e-07 0.0 4.649e-07 0.0 4.650e-07 1.8 4.699e-07 1.8 4.700e-07 0.0 4.749e-07 0.0 4.750e-07 1.8 4.799e-07 1.8 4.800e-07 1.8 4.849e-07 1.8 4.850e-07 1.8 4.899e-07 1.8 4.900e-07 0.0 4.949e-07 0.0 4.950e-07 1.8 4.999e-07 1.8 5.000e-07 0.0 5.049e-07 0.0 5.050e-07 0.0 5.099e-07 0.0 5.100e-07 0.0 5.149e-07 0.0 5.150e-07 1.8 5.199e-07 1.8 5.200e-07 0.0 5.249e-07 0.0 5.250e-07 1.8 5.299e-07 1.8 5.300e-07 1.8 5.349e-07 1.8 5.350e-07 1.8 5.399e-07 1.8 5.400e-07 0.0 5.449e-07 0.0 5.450e-07 1.8 5.499e-07 1.8 5.500e-07 0.0 5.549e-07 0.0 5.550e-07 0.0 5.599e-07 0.0 5.600e-07 0.0 5.649e-07 0.0 5.650e-07 1.8 5.699e-07 1.8 5.700e-07 0.0 5.749e-07 0.0 5.750e-07 1.8 5.799e-07 1.8 5.800e-07 1.8 5.849e-07 1.8 5.850e-07 1.8 5.899e-07 1.8 5.900e-07 0.0 5.949e-07 0.0 5.950e-07 1.8 5.999e-07 1.8 6.000e-07 0.0 6.049e-07 0.0 6.050e-07 0.0 6.099e-07 0.0 6.100e-07 0.0 6.149e-07 0.0 6.150e-07 1.8 6.199e-07 1.8 6.200e-07 1.8 6.249e-07 1.8 6.250e-07 1.8 6.299e-07 1.8 6.300e-07 1.8 6.349e-07 1.8 6.350e-07 1.8 6.399e-07 1.8 ]

V_D5 (D5 0) vsource type=pwl wave=[ 0.000e+00 1.8 4.920e-09 1.8 5.000e-09 1.8 9.920e-09 1.8 1.000e-08 1.8 1.492e-08 1.8 1.500e-08 1.8 1.992e-08 1.8 2.000e-08 1.8 2.492e-08 1.8 2.500e-08 0.0 2.992e-08 0.0 3.000e-08 0.0 3.492e-08 0.0 3.500e-08 0.0 3.992e-08 0.0 4.000e-08 0.0 4.492e-08 0.0 4.500e-08 0.0 4.992e-08 0.0 5.000e-08 1.8 5.492e-08 1.8 5.500e-08 1.8 5.992e-08 1.8 6.000e-08 1.8 6.492e-08 1.8 6.500e-08 1.8 6.992e-08 1.8 7.000e-08 1.8 7.492e-08 1.8 7.500e-08 0.0 7.992e-08 0.0 8.000e-08 0.0 8.492e-08 0.0 8.500e-08 0.0 8.992e-08 0.0 9.000e-08 0.0 9.492e-08 0.0 9.500e-08 0.0 9.992e-08 0.0 1.000e-07 1.8 1.049e-07 1.8 1.050e-07 1.8 1.099e-07 1.8 1.100e-07 1.8 1.149e-07 1.8 1.150e-07 1.8 1.199e-07 1.8 1.200e-07 1.8 1.249e-07 1.8 1.250e-07 0.0 1.299e-07 0.0 1.300e-07 0.0 1.349e-07 0.0 1.350e-07 0.0 1.399e-07 0.0 1.400e-07 0.0 1.449e-07 0.0 1.450e-07 0.0 1.499e-07 0.0 1.500e-07 1.8 1.549e-07 1.8 1.550e-07 1.8 1.599e-07 1.8 1.600e-07 1.8 1.649e-07 1.8 1.650e-07 1.8 1.699e-07 1.8 1.700e-07 1.8 1.749e-07 1.8 1.750e-07 0.0 1.799e-07 0.0 1.800e-07 0.0 1.849e-07 0.0 1.850e-07 0.0 1.899e-07 0.0 1.900e-07 0.0 1.949e-07 0.0 1.950e-07 0.0 1.999e-07 0.0 2.000e-07 1.8 2.049e-07 1.8 2.050e-07 1.8 2.099e-07 1.8 2.100e-07 1.8 2.149e-07 1.8 2.150e-07 1.8 2.199e-07 1.8 2.200e-07 1.8 2.249e-07 1.8 2.250e-07 0.0 2.299e-07 0.0 2.300e-07 0.0 2.349e-07 0.0 2.350e-07 0.0 2.399e-07 0.0 2.400e-07 0.0 2.449e-07 0.0 2.450e-07 0.0 2.499e-07 0.0 2.500e-07 1.8 2.549e-07 1.8 2.550e-07 1.8 2.599e-07 1.8 2.600e-07 1.8 2.649e-07 1.8 2.650e-07 1.8 2.699e-07 1.8 2.700e-07 1.8 2.749e-07 1.8 2.750e-07 0.0 2.799e-07 0.0 2.800e-07 0.0 2.849e-07 0.0 2.850e-07 0.0 2.899e-07 0.0 2.900e-07 0.0 2.949e-07 0.0 2.950e-07 0.0 2.999e-07 0.0 3.000e-07 1.8 3.049e-07 1.8 3.050e-07 1.8 3.099e-07 1.8 3.100e-07 1.8 3.149e-07 1.8 3.150e-07 1.8 3.199e-07 1.8 3.200e-07 1.8 3.249e-07 1.8 3.250e-07 0.0 3.299e-07 0.0 3.300e-07 0.0 3.349e-07 0.0 3.350e-07 0.0 3.399e-07 0.0 3.400e-07 0.0 3.449e-07 0.0 3.450e-07 1.8 3.499e-07 1.8 3.500e-07 1.8 3.549e-07 1.8 3.550e-07 1.8 3.599e-07 1.8 3.600e-07 1.8 3.649e-07 1.8 3.650e-07 1.8 3.699e-07 1.8 3.700e-07 0.0 3.749e-07 0.0 3.750e-07 0.0 3.799e-07 0.0 3.800e-07 0.0 3.849e-07 0.0 3.850e-07 0.0 3.899e-07 0.0 3.900e-07 0.0 3.949e-07 0.0 3.950e-07 1.8 3.999e-07 1.8 4.000e-07 1.8 4.049e-07 1.8 4.050e-07 1.8 4.099e-07 1.8 4.100e-07 1.8 4.149e-07 1.8 4.150e-07 1.8 4.199e-07 1.8 4.200e-07 0.0 4.249e-07 0.0 4.250e-07 0.0 4.299e-07 0.0 4.300e-07 0.0 4.349e-07 0.0 4.350e-07 0.0 4.399e-07 0.0 4.400e-07 0.0 4.449e-07 0.0 4.450e-07 1.8 4.499e-07 1.8 4.500e-07 1.8 4.549e-07 1.8 4.550e-07 1.8 4.599e-07 1.8 4.600e-07 1.8 4.649e-07 1.8 4.650e-07 1.8 4.699e-07 1.8 4.700e-07 0.0 4.749e-07 0.0 4.750e-07 0.0 4.799e-07 0.0 4.800e-07 0.0 4.849e-07 0.0 4.850e-07 0.0 4.899e-07 0.0 4.900e-07 0.0 4.949e-07 0.0 4.950e-07 1.8 4.999e-07 1.8 5.000e-07 1.8 5.049e-07 1.8 5.050e-07 1.8 5.099e-07 1.8 5.100e-07 1.8 5.149e-07 1.8 5.150e-07 1.8 5.199e-07 1.8 5.200e-07 0.0 5.249e-07 0.0 5.250e-07 0.0 5.299e-07 0.0 5.300e-07 0.0 5.349e-07 0.0 5.350e-07 0.0 5.399e-07 0.0 5.400e-07 0.0 5.449e-07 0.0 5.450e-07 1.8 5.499e-07 1.8 5.500e-07 1.8 5.549e-07 1.8 5.550e-07 1.8 5.599e-07 1.8 5.600e-07 1.8 5.649e-07 1.8 5.650e-07 1.8 5.699e-07 1.8 5.700e-07 0.0 5.749e-07 0.0 5.750e-07 0.0 5.799e-07 0.0 5.800e-07 0.0 5.849e-07 0.0 5.850e-07 0.0 5.899e-07 0.0 5.900e-07 0.0 5.949e-07 0.0 5.950e-07 1.8 5.999e-07 1.8 6.000e-07 1.8 6.049e-07 1.8 6.050e-07 1.8 6.099e-07 1.8 6.100e-07 1.8 6.149e-07 1.8 6.150e-07 1.8 6.199e-07 1.8 6.200e-07 0.0 6.249e-07 0.0 6.250e-07 0.0 6.299e-07 0.0 6.300e-07 0.0 6.349e-07 0.0 6.350e-07 0.0 6.399e-07 0.0 ]
V_DB5 (DB5 0) vsource type=pwl wave=[ 0.000e+00 0.0 4.920e-09 0.0 5.000e-09 0.0 9.920e-09 0.0 1.000e-08 0.0 1.492e-08 0.0 1.500e-08 0.0 1.992e-08 0.0 2.000e-08 0.0 2.492e-08 0.0 2.500e-08 1.8 2.992e-08 1.8 3.000e-08 1.8 3.492e-08 1.8 3.500e-08 1.8 3.992e-08 1.8 4.000e-08 1.8 4.492e-08 1.8 4.500e-08 1.8 4.992e-08 1.8 5.000e-08 0.0 5.492e-08 0.0 5.500e-08 0.0 5.992e-08 0.0 6.000e-08 0.0 6.492e-08 0.0 6.500e-08 0.0 6.992e-08 0.0 7.000e-08 0.0 7.492e-08 0.0 7.500e-08 1.8 7.992e-08 1.8 8.000e-08 1.8 8.492e-08 1.8 8.500e-08 1.8 8.992e-08 1.8 9.000e-08 1.8 9.492e-08 1.8 9.500e-08 1.8 9.992e-08 1.8 1.000e-07 0.0 1.049e-07 0.0 1.050e-07 0.0 1.099e-07 0.0 1.100e-07 0.0 1.149e-07 0.0 1.150e-07 0.0 1.199e-07 0.0 1.200e-07 0.0 1.249e-07 0.0 1.250e-07 1.8 1.299e-07 1.8 1.300e-07 1.8 1.349e-07 1.8 1.350e-07 1.8 1.399e-07 1.8 1.400e-07 1.8 1.449e-07 1.8 1.450e-07 1.8 1.499e-07 1.8 1.500e-07 0.0 1.549e-07 0.0 1.550e-07 0.0 1.599e-07 0.0 1.600e-07 0.0 1.649e-07 0.0 1.650e-07 0.0 1.699e-07 0.0 1.700e-07 0.0 1.749e-07 0.0 1.750e-07 1.8 1.799e-07 1.8 1.800e-07 1.8 1.849e-07 1.8 1.850e-07 1.8 1.899e-07 1.8 1.900e-07 1.8 1.949e-07 1.8 1.950e-07 1.8 1.999e-07 1.8 2.000e-07 0.0 2.049e-07 0.0 2.050e-07 0.0 2.099e-07 0.0 2.100e-07 0.0 2.149e-07 0.0 2.150e-07 0.0 2.199e-07 0.0 2.200e-07 0.0 2.249e-07 0.0 2.250e-07 1.8 2.299e-07 1.8 2.300e-07 1.8 2.349e-07 1.8 2.350e-07 1.8 2.399e-07 1.8 2.400e-07 1.8 2.449e-07 1.8 2.450e-07 1.8 2.499e-07 1.8 2.500e-07 0.0 2.549e-07 0.0 2.550e-07 0.0 2.599e-07 0.0 2.600e-07 0.0 2.649e-07 0.0 2.650e-07 0.0 2.699e-07 0.0 2.700e-07 0.0 2.749e-07 0.0 2.750e-07 1.8 2.799e-07 1.8 2.800e-07 1.8 2.849e-07 1.8 2.850e-07 1.8 2.899e-07 1.8 2.900e-07 1.8 2.949e-07 1.8 2.950e-07 1.8 2.999e-07 1.8 3.000e-07 0.0 3.049e-07 0.0 3.050e-07 0.0 3.099e-07 0.0 3.100e-07 0.0 3.149e-07 0.0 3.150e-07 0.0 3.199e-07 0.0 3.200e-07 0.0 3.249e-07 0.0 3.250e-07 1.8 3.299e-07 1.8 3.300e-07 1.8 3.349e-07 1.8 3.350e-07 1.8 3.399e-07 1.8 3.400e-07 1.8 3.449e-07 1.8 3.450e-07 0.0 3.499e-07 0.0 3.500e-07 0.0 3.549e-07 0.0 3.550e-07 0.0 3.599e-07 0.0 3.600e-07 0.0 3.649e-07 0.0 3.650e-07 0.0 3.699e-07 0.0 3.700e-07 1.8 3.749e-07 1.8 3.750e-07 1.8 3.799e-07 1.8 3.800e-07 1.8 3.849e-07 1.8 3.850e-07 1.8 3.899e-07 1.8 3.900e-07 1.8 3.949e-07 1.8 3.950e-07 0.0 3.999e-07 0.0 4.000e-07 0.0 4.049e-07 0.0 4.050e-07 0.0 4.099e-07 0.0 4.100e-07 0.0 4.149e-07 0.0 4.150e-07 0.0 4.199e-07 0.0 4.200e-07 1.8 4.249e-07 1.8 4.250e-07 1.8 4.299e-07 1.8 4.300e-07 1.8 4.349e-07 1.8 4.350e-07 1.8 4.399e-07 1.8 4.400e-07 1.8 4.449e-07 1.8 4.450e-07 0.0 4.499e-07 0.0 4.500e-07 0.0 4.549e-07 0.0 4.550e-07 0.0 4.599e-07 0.0 4.600e-07 0.0 4.649e-07 0.0 4.650e-07 0.0 4.699e-07 0.0 4.700e-07 1.8 4.749e-07 1.8 4.750e-07 1.8 4.799e-07 1.8 4.800e-07 1.8 4.849e-07 1.8 4.850e-07 1.8 4.899e-07 1.8 4.900e-07 1.8 4.949e-07 1.8 4.950e-07 0.0 4.999e-07 0.0 5.000e-07 0.0 5.049e-07 0.0 5.050e-07 0.0 5.099e-07 0.0 5.100e-07 0.0 5.149e-07 0.0 5.150e-07 0.0 5.199e-07 0.0 5.200e-07 1.8 5.249e-07 1.8 5.250e-07 1.8 5.299e-07 1.8 5.300e-07 1.8 5.349e-07 1.8 5.350e-07 1.8 5.399e-07 1.8 5.400e-07 1.8 5.449e-07 1.8 5.450e-07 0.0 5.499e-07 0.0 5.500e-07 0.0 5.549e-07 0.0 5.550e-07 0.0 5.599e-07 0.0 5.600e-07 0.0 5.649e-07 0.0 5.650e-07 0.0 5.699e-07 0.0 5.700e-07 1.8 5.749e-07 1.8 5.750e-07 1.8 5.799e-07 1.8 5.800e-07 1.8 5.849e-07 1.8 5.850e-07 1.8 5.899e-07 1.8 5.900e-07 1.8 5.949e-07 1.8 5.950e-07 0.0 5.999e-07 0.0 6.000e-07 0.0 6.049e-07 0.0 6.050e-07 0.0 6.099e-07 0.0 6.100e-07 0.0 6.149e-07 0.0 6.150e-07 0.0 6.199e-07 0.0 6.200e-07 1.8 6.249e-07 1.8 6.250e-07 1.8 6.299e-07 1.8 6.300e-07 1.8 6.349e-07 1.8 6.350e-07 1.8 6.399e-07 1.8 ]

X_DUT (VDD VSS D0 DB0 D1 DB1 D2 DB2 D3 DB3 D4 DB4 D5 DB5 VOUTP VOUTN) dac_6bit_core

tran tran stop=6.400e-07 step=20p errpreset=conservative
save VOUTP VOUTN
simulatorOptions options reltol=1e-4 vabstol=1e-6 iabstol=1e-12 rawfmt=psfascii
